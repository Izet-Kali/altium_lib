D:\DATA\MY CIRCUITS\MC33178\MC33178 TELEPHONE LINE INTERFACE VTIP.CIR SETUP1
*#SAVE V(6) V(1) V(2) V(4) @VCC[I] @VCC[P] @VEE[I] @VEE[P]
*#SAVE @R1[I] @R1[P] @R2[I] @R2[P] V(7) V(9) @R4[I] @R4[P]
*#SAVE V(17) @R5[I] @R5[P] V(14) @R6[I] @R6[P] V(10) @R7[I]
*#SAVE @R7[P] @C3[I] V(11) @R8[I] @R8[P] V(12) V(20) @R9[I]
*#SAVE @R9[P] V(13) @R10[I] @R10[P] @C4[I] @R11[I] @R11[P] @RLOAD[I]
*#SAVE @RLOAD[P] V(15) @C1[I] V(3) @R13[I] @R13[P]
*#ALIAS VRECEIVE  V(20)
*#VIEW  TRAN VRECEIVE -5 5
*#ALIAS VINX3  V(14)
*#VIEW  TRAN VINX3 -5 5
*#ALIAS VOUTX2  V(4)
*#VIEW  TRAN VOUTX2 -5 5
*#ALIAS VOUTX1  V(7)
*#VIEW  TRAN VOUTX1 -5 5
*#ALIAS VTIP  V(3)
*#VIEW  TRAN VTIP -5 5
.TRAN 5MS 50MS
.PRINT  TRAN VRECEIVE
.PRINT  TRAN VINX3
.PRINT  TRAN VOUTX2
.PRINT  TRAN VOUTX1
.PRINT  TRAN VTIP
X2 0 6 1 2 4 MC33178#0
*{  }
.SUBCKT MC33178#0  1 2 3 4 5
*
C1   11 12 8.660E-12
C2    6  7 15.00E-12
DC    5 53 DX
DE   54  5 DX
DLP  90 91 DX
DLN  92 90 DX
DP    4  3 DX
EGND 99  0 POLY(2) (3,0) (4,0) 0 .5 .5
FB    7 99 POLY(5) VB VC VE VLP VLN 0 17.68E6
+ -20E6 20E6 20E6 -20E6
GA    6  0 11 12 282.7E-6
GCM   0  6 10 99 894.1E-12
IEE   3 10 DC 30.20E-6
HLIM 90  0 VLIM 1K
Q1   11  2 13 QX
Q2   12  1 14 QX
R2    6  9 100.0E3
RC1   4 11 3.537E3
RC2   4 12 3.537E3
RE1  13 10 1.800E3
RE2  14 10 1.800E3
REE  10 99 6.623E6
RO1   8  5 60
RO2   7 99 40
RP    3  4 164.5E3
VB    9  0 DC 0
VC    3 53 DC 1
VE   54  4 DC 1.200
VLIM  7  8 DC 0
VLP  91  0 DC 100
VLN   0 92 DC 100
DESD1  1  3 DX
DESD2  2  3 DX
.MODEL DX D(IS=800.0E-18)
.MODEL QX PNP(IS=800.0E-18 BF=150)
.ENDS
VCC 1 0 DC=15V
VEE 2 0 DC=-15V
R1 6 7 10K
X6 3 0 SINE#0
*{ AMPLITUDE=2 FREQ=200 }
.SUBCKT SINE#0 1 2
*PARAMETERS:
* OFFSET DC VOLTAGE OFFSET IN VOLTS
* AMP AMPLITUDE IN VOLTS
* FREQ FREQUENCY IN HZ
* DELAY TIME DELAY IN SECONDS
* DAMP DAMPING FACTOR (SEE SIN SOURCE FOR DEFINITION)
V1 1 2 SIN 0 2.0000  200.00  0 0
R1 1 2 1MEG
.ENDS
X1 0 9 1 2 7 MC33178#0
*{  }
R2 6 4 10K
R4 9 7 120K
C1 0 20 .01UF
R5 17 9 2K
R6 7 14 820
R7 7 10 300
C3 10 14 .05UF
R8 11 7 200K
X3 12 11 1 2 20 MC33178#0
*{  }
R9 12 14 10K
R10 12 13 10K
C4 13 0 1.0UF
R11 20 11 10K
RLOAD 20 0 50
X6X 14 15 1N4678#0
*{  }
.SUBCKT 1N4678#0 2 1
* MODEL GENERATED ON JUN 21, 00
* MODEL FORMAT: SPICE3
*     ANODE CATHODE
*NODE: 2      1
*    FORWARD SECTION
D1 2 1 MD1 TEMP=25
.MODEL MD1 D IS=8.943E-18 N=0.88266 XTI=1 RS=10
+ CJO=2.95E-10 TT=1.0079E-07
*    LEAKAGE CURRENT
R 1 2 1.66667E+06 MDR
.MODEL MDR R TC1=0 TC2=0
*    BREAKDOWN
RZ 2 3 361.752
IZG 4 3 0.00015
R4 4 3 100000
D3 3 4 MD3 TEMP=25
.MODEL MD3 D IS=2.5E-12 N=0.626212 XTI=0 EG=0.1
D2 5 4 MD2 TEMP=25
.MODEL MD2 D IS=2.5E-12 N=1.17214 XTI=0 EG=0.1
EV1 1 5 6 0 1
IBV 0 6 0.001
RBV 6 0 1748.9 MDRBV
.MODEL MDRBV R TC1=0
*-- SPICE3 DIODE MODEL DEFAULT PARAMETER
*  VALUES ARE ASSUMED
*IS=1E-14 RS=0 N=1 TT=0 CJO=0
*VJ=1 M=0.5 EG=1.11 XTI=3 FC=0.5
*KF=0 AF=1 BV=INF IBV=1E-3 TNOM=27
.ENDS 1N4678
X7 4 15 1N4678#0
*{  }
R13 17 0 10M
X9 14 4 3 0 XFMR#0
*{ RATIO=1:1 }
.SUBCKT XFMR#0 1    2    3    4
*CONNECTIONS +PRI -PRI +SEC -SEC
*PARAMETERS:
* RATIO = SECONDARY/PRIMARY TURNS RATIO
*
*  1_______   _______3
*    +     ) (     +
*          ) (
*    V1    ) (     V2
*          ) (
*    -     ) (     -
*  2_______) (_______4
*
*         1 : RATIO
*
RP 1 2 1MEG
E 5 4 1 2 1.0000
F 1 2 VM 1.0000
RS 6 3 1U
VM 5 6
.ENDS
.END
